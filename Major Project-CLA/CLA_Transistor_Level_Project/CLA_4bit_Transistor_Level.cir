* ==============================================================
* 4-BIT CARRY LOOK-AHEAD ADDER (CLA) - TRANSISTOR LEVEL
* Static CMOS implementation using generic Level-1 MOS models
* Cin is fixed at logic 0. Inputs A[3:0], B[3:0].
* Open this .cir file in LTspice and click Run.
* ==============================================================

.title 4-bit Transistor-Level Carry Look-Ahead Adder

* Supply
VDD VDD 0 DC 5

* Generic educational MOSFET models (not process-calibrated)
.model NM NMOS (LEVEL=1 VTO=0.7 KP=120u LAMBDA=0.02)
.model PM PMOS (LEVEL=1 VTO=-0.7 KP=50u LAMBDA=0.02)

* ---------------- CMOS primitive gates ----------------
.SUBCKT INV A Y VDD VSS
MP1 Y A VDD VDD PM W=4u L=1u
MN1 Y A VSS VSS NM W=2u L=1u
.ENDS INV

.SUBCKT NAND2 A B Y VDD VSS
MP1 Y A VDD VDD PM W=4u L=1u
MP2 Y B VDD VDD PM W=4u L=1u
MN1 Y A N1 VSS NM W=4u L=1u
MN2 N1 B VSS VSS NM W=4u L=1u
.ENDS NAND2

.SUBCKT NAND3 A B C Y VDD VSS
MP1 Y A VDD VDD PM W=4u L=1u
MP2 Y B VDD VDD PM W=4u L=1u
MP3 Y C VDD VDD PM W=4u L=1u
MN1 Y A N1 VSS NM W=6u L=1u
MN2 N1 B N2 VSS NM W=6u L=1u
MN3 N2 C VSS VSS NM W=6u L=1u
.ENDS NAND3

.SUBCKT NAND4 A B C D Y VDD VSS
MP1 Y A VDD VDD PM W=4u L=1u
MP2 Y B VDD VDD PM W=4u L=1u
MP3 Y C VDD VDD PM W=4u L=1u
MP4 Y D VDD VDD PM W=4u L=1u
MN1 Y A N1 VSS NM W=8u L=1u
MN2 N1 B N2 VSS NM W=8u L=1u
MN3 N2 C N3 VSS NM W=8u L=1u
MN4 N3 D VSS VSS NM W=8u L=1u
.ENDS NAND4

* AND2 = NAND2 followed by inverter
.SUBCKT AND2 A B Y VDD VSS
XG1 A B N1 VDD VSS NAND2
XG2 N1 Y VDD VSS INV
.ENDS AND2

* XOR2 implemented with four CMOS NAND2 gates
.SUBCKT XOR2 A B Y VDD VSS
X1 A B N1 VDD VSS NAND2
X2 A N1 N2 VDD VSS NAND2
X3 B N1 N3 VDD VSS NAND2
X4 N2 N3 Y VDD VSS NAND2
.ENDS XOR2

* ---------------- Input stimulus ----------------
* A inputs count through 0000 to 1111 repeatedly.
* B inputs change after each complete 16-state A sequence.
* The combined sequence covers all 256 (A,B) combinations.
VA0 A0 0 PULSE(0 5 0 0.5n 0.5n 10n 20n)
VA1 A1 0 PULSE(0 5 0 0.5n 0.5n 20n 40n)
VA2 A2 0 PULSE(0 5 0 0.5n 0.5n 40n 80n)
VA3 A3 0 PULSE(0 5 0 0.5n 0.5n 80n 160n)

VB0 B0 0 PULSE(0 5 0 0.5n 0.5n 160n 320n)
VB1 B1 0 PULSE(0 5 0 0.5n 0.5n 320n 640n)
VB2 B2 0 PULSE(0 5 0 0.5n 0.5n 640n 1.28u)
VB3 B3 0 PULSE(0 5 0 0.5n 0.5n 1.28u 2.56u)

* ---------------- Propagate and Generate ----------------
* Pi = Ai XOR Bi ; Gi = Ai AND Bi
XP0 A0 B0 P0 VDD 0 XOR2
XP1 A1 B1 P1 VDD 0 XOR2
XP2 A2 B2 P2 VDD 0 XOR2
XP3 A3 B3 P3 VDD 0 XOR2

XG0 A0 B0 G0 VDD 0 AND2
XG1 A1 B1 G1 VDD 0 AND2
XG2 A2 B2 G2 VDD 0 AND2
XG3 A3 B3 G3 VDD 0 AND2

* ---------------- Look-ahead carry network ----------------
* Cin = C0 = 0
* C1 = G0
* C2 = G1 + P1.G0
* C3 = G2 + P2.G1 + P2.P1.G0
* C4 = G3 + P3.G2 + P3.P2.G1 + P3.P2.P1.G0

* C1 is directly G0
* C2 = NAND( NOT(G1), NOT(P1.G0) )
XIG1 G1 NG1 VDD 0 INV
XT20 P1 G0 NT20 VDD 0 NAND2
XC2 NG1 NT20 C2 VDD 0 NAND2

* C3
XIG2 G2 NG2 VDD 0 INV
XT31 P2 G1 NT31 VDD 0 NAND2
XT32 P2 P1 G0 NT32 VDD 0 NAND3
XC3 NG2 NT31 NT32 C3 VDD 0 NAND3

* C4
XIG3 G3 NG3 VDD 0 INV
XT41 P3 G2 NT41 VDD 0 NAND2
XT42 P3 P2 G1 NT42 VDD 0 NAND3
XT43 P3 P2 P1 G0 NT43 VDD 0 NAND4
XC4 NG3 NT41 NT42 NT43 C4 VDD 0 NAND4

* ---------------- Sum network ----------------
* Si = Pi XOR Ci
* C0 is tied to ground, so S0 = P0
XS1 P1 G0 S1 VDD 0 XOR2
XS2 P2 C2 S2 VDD 0 XOR2
XS3 P3 C3 S3 VDD 0 XOR2
* S0 = P0 (Cin = 0)
* Expose C1..C4 and P0 as named output nodes.
* Output bus: S3 S2 S1 S0 ; final carry: C4

* ---------------- Transient analysis ----------------
.options method=gear
.options gmin=1e-9
.options cshunt=1e-12
.options reltol=0.02
.options abstol=1e-9
.options vntol=1e-3
.tran 0 2.56u 0 1n

* Useful saved traces for plotting in LTspice
.save V(A0) V(A1) V(A2) V(A3) V(B0) V(B1) V(B2) V(B3)
.save V(P0) V(P1) V(P2) V(P3) V(G0) V(G1) V(G2) V(G3)
.save V(C2) V(C3) V(C4) V(S1) V(S2) V(S3) V(VDD)

.end
